# Ansys Electronics Desktop project, version 2024.2
project variables:
  $material_index = 0
materials:
  vacuum: permittivity=1
  FR4_epoxy: permittivity=4.4 dielectric_loss_tangent=0.02
  air: permittivity=1.0006 permeability=1.0000004
  copper: permeability=0.999991 conductivity=58000000
  water_distilled: permittivity=81 permeability=0.999991 conductivity=0.0002
  water_sea: permittivity=81 permeability=0.999991 conductivity=4
  diamond: permittivity=16.5
  glass: permittivity=5.5
  nickel, DC: permeability=600 conductivity=14500000
  Material1: permittivity=1

design MCSRR_3_Rings (HFSS, HFSS Modal Network, model units mm)
geometry:
  Substrate [FR4_epoxy] = box(corner=(-12.5mm, -17.5mm, 0mm), size=(25mm, 35mm, 1.5mm))
  Cylinder1 = cylinder(axis=Z, base_centre=(0mm, 0mm, 3mm), radius=0.75mm, height=-12mm)
  Cylinder1_1 = Cylinder1.copy()
  Cylinder1_2 = Cylinder1.copy()
  Cylinder1_3 = Cylinder1.copy()
  Substrate.subtract(Cylinder1)
  Ground_Plane = rectangle(corner=(-12.5mm, 17.5mm, 1.5mm), x_size=25mm, y_size=-35mm)
  Outer_Circle = circle(normal=Z, centre=(0mm, 0mm, 1.5mm), radius=4.65mm)
  Circle1 = circle(normal=Z, centre=(0mm, 0mm, 1.5mm), radius=4.3mm)
  Outer_Circle.subtract(Circle1)
  Ground_Plane.subtract(Outer_Circle)
  Box1 = box(corner=(-4.65mm, 0mm, -1mm), size=(0.35mm, 0.7mm, 7mm))
  Ground_Plane.subtract(Box1)
  Almost_Outer_Circle = circle(normal=Z, centre=(0mm, 0mm, 1.5mm), radius=4mm)
  Circle2 = circle(normal=Z, centre=(0mm, 0mm, 1.5mm), radius=3.65mm)
  Almost_Outer_Circle.subtract(Circle2)
  Ground_Plane.subtract(Almost_Outer_Circle)
  Circle3 = circle(normal=Z, centre=(0mm, 0mm, 1.5mm), radius=3.35mm)
  Circle4 = circle(normal=Z, centre=(0mm, 0mm, 1.5mm), radius=3mm)
  Circle3.subtract(Circle4)
  Ground_Plane.subtract(Circle3)
  Circle5 = circle(normal=Z, centre=(0mm, 0mm, 1.5mm), radius=2.7mm)
  Circle6 = circle(normal=Z, centre=(0mm, 0mm, 1.5mm), radius=2.35mm)
  Circle5.subtract(Circle6)
  Ground_Plane.subtract(Circle5)
  Rectangle4 = rectangle(corner=(3.6mm, -0.35mm, 1.5mm), x_size=0.4mm, y_size=0.7mm)
  Ground_Plane.unite(Rectangle4)
  Rectangle3 = rectangle(corner=(2.3mm, -0.35mm, 1.5mm), x_size=0.4mm, y_size=0.7mm)
  Ground_Plane.unite(Rectangle3)
  Rectangle2 = rectangle(corner=(-3.35mm, -0.35mm, 1.5mm), x_size=0.4mm, y_size=0.7mm)
  Ground_Plane.unite(Rectangle2)
  Rectangle1 = rectangle(corner=(-4.65mm, -0.35mm, 1.5mm), x_size=0.4mm, y_size=0.7mm)
  Ground_Plane.unite(Rectangle1)
  Ground_Plane.subtract(Cylinder1_1)
  Ground_Plane.thicken(-35um)
  Microstrip_Circle [copper] = circle(normal=Z, centre=(0mm, 0mm, 0mm), radius=4mm)
  Microstrip_Circle.subtract(Cylinder1_3)
  Microstrip = rectangle(corner=(-1.325mm, -17.5mm, 0mm), x_size=2.65mm, y_size=35mm)
  Microstrip.subtract(Cylinder1_2)
  Microstrip_Circle.unite(Microstrip)
  Microstrip_Circle.thicken(35um)
  Feedline1 = rectangle(corner=(-1.25mm, -17.5mm, 0mm), z_size=1.5mm, x_size=2.5mm)
  Feedline2 = rectangle(corner=(-1.25mm, 17.5mm, 0mm), z_size=1.5mm, x_size=2.5mm)
  Airbox [air] = box(corner=(-32.25mm, -31.75mm, -30.575mm), size=(64.5mm, 63.5mm, 61.15mm))
  Cover = circle(normal=Z, centre=(0mm, 0mm, 1.5mm), radius=4.65mm)
  Inner_cover = circle(normal=Z, centre=(0mm, 0mm, 1.5mm), radius=4.3mm)
  [Cover, Inner_cover].thicken(35um)
  Cover.subtract(Inner_cover)
  Cover.unite(Ground_Plane)
  Cover.delete()
  Patchup [copper] = imported_body()
  [Substrate, Microstrip_Circle, Feedline1, Feedline2, Airbox, Patchup].scale(2, 2, 2)
boundaries and excitations:
  Rad1: Radiation Objects=Airbox
  1: Lumped Port Objects=Feedline1 LumpedPortType=Modal Modes{Mode1{IntLine{(0, -35, 0.07) -> (0, -35, 3)} CharImp=Zpi}} Impedance=50ohm
  2: Lumped Port Objects=Feedline2 LumpedPortType=Modal Modes{Mode1{IntLine{(0, 35, 0) -> (0, 35, 3)} CharImp=Zpi}} Impedance=50ohm
setups:
  Setup1: HfssDriven Frequency=2.45GHz MaxDeltaS=0.02 MaximumPasses=10 MinimumPasses=1 MinimumConvergedPasses=1 PercentRefinement=30 BasisOrder=1 PortAccuracy=2 DrivenSolverType="Direct Solver"
    sweep Sweep: 1.225GHz to 3.675GHz step 0.01GHz; Type=Fast SaveFields
source amplitudes:
  1:1: 1V 0deg
  2:1: 0V 0deg

design MCSRR_2_Rings (HFSS, HFSS Modal Network, model units mm)
geometry:
  Substrate [FR4_epoxy] = box(corner=(-12.5mm, -17.5mm, 0mm), size=(25mm, 35mm, 1.5mm))
  Cylinder1 = cylinder(axis=Z, base_centre=(0mm, 0mm, 3mm), radius=0.75mm, height=-12mm)
  Cylinder1_1 = Cylinder1.copy()
  Cylinder1_2 = Cylinder1.copy()
  Cylinder1_3 = Cylinder1.copy()
  Substrate.subtract(Cylinder1)
  Ground_Plane = rectangle(corner=(-12.5mm, 17.5mm, 1.5mm), x_size=25mm, y_size=-35mm)
  Outer_Circle = circle(normal=Z, centre=(0mm, 0mm, 1.5mm), radius=4.65mm)
  Circle1 = circle(normal=Z, centre=(0mm, 0mm, 1.5mm), radius=4.3mm)
  Outer_Circle.subtract(Circle1)
  Ground_Plane.subtract(Outer_Circle)
  Box1 = box(corner=(-4.65mm, 0mm, -1mm), size=(0.35mm, 0.7mm, 7mm))
  Ground_Plane.subtract(Box1)
  Almost_Outer_Circle = circle(normal=Z, centre=(0mm, 0mm, 1.5mm), radius=4mm)
  Circle2 = circle(normal=Z, centre=(0mm, 0mm, 1.5mm), radius=3.65mm)
  Almost_Outer_Circle.subtract(Circle2)
  Ground_Plane.subtract(Almost_Outer_Circle)
  Circle3 = circle(normal=Z, centre=(0mm, 0mm, 1.5mm), radius=3.35mm)
  Circle4 = circle(normal=Z, centre=(0mm, 0mm, 1.5mm), radius=3mm)
  Circle3.subtract(Circle4)
  Ground_Plane.subtract(Circle3)
  Circle5 = circle(normal=Z, centre=(0mm, 0mm, 1.5mm), radius=2.7mm)
  Circle6 = circle(normal=Z, centre=(0mm, 0mm, 1.5mm), radius=2.35mm)
  Circle5.subtract(Circle6)
  Ground_Plane.subtract(Circle5)
  Rectangle4 = rectangle(corner=(3.6mm, -0.35mm, 1.5mm), x_size=0.4mm, y_size=0.7mm)
  Ground_Plane.unite(Rectangle4)
  Rectangle3 = rectangle(corner=(2.3mm, -0.35mm, 1.5mm), x_size=0.4mm, y_size=0.7mm)
  Ground_Plane.unite(Rectangle3)
  Rectangle2 = rectangle(corner=(-3.35mm, -0.35mm, 1.5mm), x_size=0.4mm, y_size=0.7mm)
  Ground_Plane.unite(Rectangle2)
  Rectangle1 = rectangle(corner=(-4.65mm, -0.35mm, 1.5mm), x_size=0.4mm, y_size=0.7mm)
  Ground_Plane.unite(Rectangle1)
  Ground_Plane.subtract(Cylinder1_1)
  Ground_Plane.thicken(-35um)
  Microstrip_Circle [copper] = circle(normal=Z, centre=(0mm, 0mm, 0mm), radius=3.35mm)
  Microstrip_Circle.subtract(Cylinder1_3)
  Microstrip = rectangle(corner=(-1.325mm, -17.5mm, 0mm), x_size=2.65mm, y_size=35mm)
  Microstrip.subtract(Cylinder1_2)
  Microstrip_Circle.unite(Microstrip)
  Microstrip_Circle.thicken(35um)
  Feedline1 = rectangle(corner=(-1.25mm, -17.5mm, 0mm), z_size=1.5mm, x_size=2.5mm)
  Feedline2 = rectangle(corner=(-1.25mm, 17.5mm, 0mm), z_size=1.5mm, x_size=2.5mm)
  Airbox [air] = box(corner=(-32.25mm, -31.75mm, -30.575mm), size=(64.5mm, 63.5mm, 61.15mm))
  Cover = circle(normal=Z, centre=(0mm, 0mm, 1.5mm), radius=4.65mm)
  Inner_cover = circle(normal=Z, centre=(0mm, 0mm, 1.5mm), radius=4.3mm)
  [Cover, Inner_cover].thicken(35um)
  Cover.subtract(Inner_cover)
  Cover.unite(Ground_Plane)
  Cover.delete()
  Patchup [copper] = imported_body()
  cover_2 = circle(normal=Z, centre=(0mm, 0mm, 1.5mm), radius=4.5mm)
  inner_2 = circle(normal=Z, centre=(0mm, 0mm, 1.5mm), radius=3.5mm)
  [cover_2, inner_2].thicken(35um)
  cover_2.subtract(inner_2)
  Patchup.unite(cover_2)
boundaries and excitations:
  Rad1: Radiation Objects=Airbox
  1: Lumped Port Objects=Feedline1 LumpedPortType=Modal Modes{Mode1{IntLine{(0, -17.5, 0.035) -> (0, -17.5, 1.5)} CharImp=Zpi}} Impedance=50ohm
  2: Lumped Port Objects=Feedline2 LumpedPortType=Modal Modes{Mode1{IntLine{(0, 17.5, 0) -> (0, 17.5, 1.5)} CharImp=Zpi}} Impedance=50ohm
setups:
  Setup1: HfssDriven Frequency=2.45GHz MaxDeltaS=0.02 MaximumPasses=10 MinimumPasses=1 MinimumConvergedPasses=1 PercentRefinement=30 BasisOrder=1 PortAccuracy=2 DrivenSolverType="Direct Solver"
    sweep Sweep: 1.225GHz to 3.675GHz step 0.01GHz; Type=Fast SaveFields
source amplitudes:
  1:1: 1V 0deg
  2:1: 0V 0deg
reports:
  S Parameter Plot 1: dB(S(1,1)), dB(S(2,1)) vs Freq on Setup1 : Sweep; markers m1 at 3.385GHz

design MCSRR_1_Ring (HFSS, HFSS Modal Network, model units mm)
geometry:
  Substrate [FR4_epoxy] = box(corner=(-12.5mm, -17.5mm, 0mm), size=(25mm, 35mm, 1.5mm))
  Cylinder1 = cylinder(axis=Z, base_centre=(0mm, 0mm, 3mm), radius=0.75mm, height=-12mm)
  Cylinder1_1 = Cylinder1.copy()
  Cylinder1_2 = Cylinder1.copy()
  Cylinder1_3 = Cylinder1.copy()
  Substrate.subtract(Cylinder1)
  Ground_Plane = rectangle(corner=(-12.5mm, 17.5mm, 1.5mm), x_size=25mm, y_size=-35mm)
  Outer_Circle = circle(normal=Z, centre=(0mm, 0mm, 1.5mm), radius=4.65mm)
  Circle1 = circle(normal=Z, centre=(0mm, 0mm, 1.5mm), radius=4.3mm)
  Outer_Circle.subtract(Circle1)
  Ground_Plane.subtract(Outer_Circle)
  Box1 = box(corner=(-4.65mm, 0mm, -1mm), size=(0.35mm, 0.7mm, 7mm))
  Ground_Plane.subtract(Box1)
  Almost_Outer_Circle = circle(normal=Z, centre=(0mm, 0mm, 1.5mm), radius=4mm)
  Circle2 = circle(normal=Z, centre=(0mm, 0mm, 1.5mm), radius=3.65mm)
  Almost_Outer_Circle.subtract(Circle2)
  Ground_Plane.subtract(Almost_Outer_Circle)
  Circle3 = circle(normal=Z, centre=(0mm, 0mm, 1.5mm), radius=3.35mm)
  Circle4 = circle(normal=Z, centre=(0mm, 0mm, 1.5mm), radius=3mm)
  Circle3.subtract(Circle4)
  Ground_Plane.subtract(Circle3)
  Circle5 = circle(normal=Z, centre=(0mm, 0mm, 1.5mm), radius=2.7mm)
  Circle6 = circle(normal=Z, centre=(0mm, 0mm, 1.5mm), radius=2.35mm)
  Circle5.subtract(Circle6)
  Ground_Plane.subtract(Circle5)
  Rectangle4 = rectangle(corner=(3.6mm, -0.35mm, 1.5mm), x_size=0.4mm, y_size=0.7mm)
  Ground_Plane.unite(Rectangle4)
  Rectangle3 = rectangle(corner=(2.3mm, -0.35mm, 1.5mm), x_size=0.4mm, y_size=0.7mm)
  Ground_Plane.unite(Rectangle3)
  Rectangle2 = rectangle(corner=(-3.35mm, -0.35mm, 1.5mm), x_size=0.4mm, y_size=0.7mm)
  Ground_Plane.unite(Rectangle2)
  Rectangle1 = rectangle(corner=(-4.65mm, -0.35mm, 1.5mm), x_size=0.4mm, y_size=0.7mm)
  Ground_Plane.unite(Rectangle1)
  Ground_Plane.subtract(Cylinder1_1)
  Ground_Plane.thicken(-35um)
  Microstrip_Circle [copper] = circle(normal=Z, centre=(0mm, 0mm, 0mm), radius=2.7mm)
  Microstrip_Circle.subtract(Cylinder1_3)
  Microstrip = rectangle(corner=(-1.325mm, -17.5mm, 0mm), x_size=2.65mm, y_size=35mm)
  Microstrip.subtract(Cylinder1_2)
  Microstrip_Circle.unite(Microstrip)
  Microstrip_Circle.thicken(35um)
  Feedline1 = rectangle(corner=(-1.25mm, -17.5mm, 0mm), z_size=1.5mm, x_size=2.5mm)
  Feedline2 = rectangle(corner=(-1.25mm, 17.5mm, 0mm), z_size=1.5mm, x_size=2.5mm)
  Airbox [air] = box(corner=(-32.25mm, -31.75mm, -30.575mm), size=(64.5mm, 63.5mm, 61.15mm))
  Cover = circle(normal=Z, centre=(0mm, 0mm, 1.5mm), radius=4.65mm)
  Inner_cover = circle(normal=Z, centre=(0mm, 0mm, 1.5mm), radius=4.3mm)
  [Cover, Inner_cover].thicken(35um)
  Cover.subtract(Inner_cover)
  Cover.unite(Ground_Plane)
  Cover.delete()
  Patchup = imported_body()
  cover_2 = circle(normal=Z, centre=(0mm, 0mm, 1.5mm), radius=4.5mm)
  inner_2 = circle(normal=Z, centre=(0mm, 0mm, 1.5mm), radius=3.5mm)
  [cover_2, inner_2].thicken(35um)
  cover_2.subtract(inner_2)
  Patchup.unite(cover_2)
  cover_3 [copper] = circle(normal=Z, centre=(0mm, 0mm, 1.5mm), radius=5mm)
  inner_3 = circle(normal=Z, centre=(0mm, 0mm, 1.5mm), radius=2.8mm)
  [cover_3, inner_3].thicken(35um)
  cover_3.subtract(inner_3)
  cover_3.unite(Patchup)
  split = rectangle(corner=(2.32379mm, 0.35mm, 1.5mm), x_size=0.3534287mm, y_size=-0.7mm)
  split.thicken(-35um)
  cover_3.subtract(split)
  Split_cover = rectangle(corner=(2.2mm, -0.7mm, 1.5mm), x_size=0.5mm, y_size=1.4mm)
  Split_cover.thicken(35um)
  cover_3.unite(Split_cover)
boundaries and excitations:
  Rad1: Radiation Objects=Airbox
  1: Lumped Port Objects=Feedline1 LumpedPortType=Modal Modes{Mode1{IntLine{(0, -17.5, 0.035) -> (0, -17.5, 1.5)} CharImp=Zpi}} Impedance=50ohm
  2: Lumped Port Objects=Feedline2 LumpedPortType=Modal Modes{Mode1{IntLine{(0, 17.5, 0) -> (0, 17.5, 1.5)} CharImp=Zpi}} Impedance=50ohm
setups:
  Setup1: HfssDriven Frequency=2.45GHz MaxDeltaS=0.02 MaximumPasses=10 MinimumPasses=1 MinimumConvergedPasses=1 PercentRefinement=30 BasisOrder=1 PortAccuracy=2 DrivenSolverType="Direct Solver"
    sweep Sweep: 1.225GHz to 7.5GHz step 0.01GHz; Type=Fast SaveFields
source amplitudes:
  1:1: 1V 0deg
  2:1: 0V 0deg
reports:
  S Parameter Plot 1: dB(S(1,1)), dB(S(2,1)) vs Freq on Setup1 : Sweep; markers m1 at 5.005GHz

design MCSRR_3_Rings_Material (HFSS, HFSS Modal Network, model units mm)
variables:
  eps_r = 4.4
geometry:
  Substrate [FR4_epoxy] = box(corner=(-12.5mm, -17.5mm, 0mm), size=(25mm, 35mm, 1.5mm))
  Cylinder1 = cylinder(axis=Z, base_centre=(0mm, 0mm, 3mm), radius=0.75mm, height=-12mm)
  Cylinder1_1 = Cylinder1.copy()
  Cylinder1_2 = Cylinder1.copy()
  Cylinder1_3 = Cylinder1.copy()
  Substrate.subtract(Cylinder1)
  Ground_Plane = rectangle(corner=(-12.5mm, 17.5mm, 1.5mm), x_size=25mm, y_size=-35mm)
  Outer_Circle = circle(normal=Z, centre=(0mm, 0mm, 1.5mm), radius=4.65mm)
  Circle1 = circle(normal=Z, centre=(0mm, 0mm, 1.5mm), radius=4.3mm)
  Outer_Circle.subtract(Circle1)
  Ground_Plane.subtract(Outer_Circle)
  Box1 = box(corner=(-4.65mm, 0mm, -1mm), size=(0.35mm, 0.7mm, 7mm))
  Ground_Plane.subtract(Box1)
  Almost_Outer_Circle = circle(normal=Z, centre=(0mm, 0mm, 1.5mm), radius=4mm)
  Circle2 = circle(normal=Z, centre=(0mm, 0mm, 1.5mm), radius=3.65mm)
  Almost_Outer_Circle.subtract(Circle2)
  Ground_Plane.subtract(Almost_Outer_Circle)
  Circle3 = circle(normal=Z, centre=(0mm, 0mm, 1.5mm), radius=3.35mm)
  Circle4 = circle(normal=Z, centre=(0mm, 0mm, 1.5mm), radius=3mm)
  Circle3.subtract(Circle4)
  Ground_Plane.subtract(Circle3)
  Circle5 = circle(normal=Z, centre=(0mm, 0mm, 1.5mm), radius=2.7mm)
  Circle6 = circle(normal=Z, centre=(0mm, 0mm, 1.5mm), radius=2.35mm)
  Circle5.subtract(Circle6)
  Ground_Plane.subtract(Circle5)
  Rectangle4 = rectangle(corner=(3.6mm, -0.35mm, 1.5mm), x_size=0.4mm, y_size=0.7mm)
  Ground_Plane.unite(Rectangle4)
  Rectangle3 = rectangle(corner=(2.3mm, -0.35mm, 1.5mm), x_size=0.4mm, y_size=0.7mm)
  Ground_Plane.unite(Rectangle3)
  Rectangle2 = rectangle(corner=(-3.35mm, -0.35mm, 1.5mm), x_size=0.4mm, y_size=0.7mm)
  Ground_Plane.unite(Rectangle2)
  Rectangle1 = rectangle(corner=(-4.65mm, -0.35mm, 1.5mm), x_size=0.4mm, y_size=0.7mm)
  Ground_Plane.unite(Rectangle1)
  Ground_Plane.subtract(Cylinder1_1)
  Ground_Plane.thicken(-35um)
  Microstrip_Circle [copper] = circle(normal=Z, centre=(0mm, 0mm, 0mm), radius=4mm)
  Microstrip_Circle.subtract(Cylinder1_3)
  Microstrip = rectangle(corner=(-1.325mm, -17.5mm, 0mm), x_size=2.65mm, y_size=35mm)
  Microstrip.subtract(Cylinder1_2)
  Microstrip_Circle.unite(Microstrip)
  Microstrip_Circle.thicken(-35um)
  Feedline1 = rectangle(corner=(-1.325mm, -17.5mm, -0.035mm), z_size=1.57mm, x_size=2.65mm)
  Feedline2 = rectangle(corner=(-1.325mm, 17.5mm, -0.035mm), z_size=1.57mm, x_size=2.65mm)
  Airbox [air] = box(corner=(-43.75mm, -48.75mm, -32mm), size=(87.5mm, 97.5mm, 64mm))
  Cover = circle(normal=Z, centre=(0mm, 0mm, 1.5mm), radius=4.65mm)
  Inner_cover = circle(normal=Z, centre=(0mm, 0mm, 1.5mm), radius=4.3mm)
  [Cover, Inner_cover].thicken(35um)
  Cover.subtract(Inner_cover)
  Cover.unite(Ground_Plane)
  Cover.delete()
  Patchup = imported_body()
  Sample [air] = cylinder(axis=Z, base_centre=(0mm, 0mm, -5.75mm), radius=0.7mm, height=13mm)
  r1_cov = rectangle(corner=(3.55mm, -0.55mm, 1.5mm), x_size=0.45mm, y_size=1.1mm)
  r1_cov.thicken(35um)
  r2_cov = rectangle(corner=(-3.35mm, -0.55mm, 1.5mm), x_size=0.45mm, y_size=1.1mm)
  r2_cov.thicken(35um)
  r3_cov [copper] = rectangle(corner=(2.25mm, -0.55mm, 1.5mm), x_size=0.45mm, y_size=1.1mm)
  r3_cov.thicken(35um)
  r3_cov.unite(r2_cov, r1_cov, Patchup)
boundaries and excitations:
  Rad1: Radiation Objects=Airbox
  1: Lumped Port Objects=Feedline1 LumpedPortType=Modal Modes{Mode1{IntLine{(0, -17.5, -0.035) -> (0, -17.5, 1.535)} CharImp=Zpi}} Impedance=50ohm
  2: Lumped Port Objects=Feedline2 LumpedPortType=Modal Modes{Mode1{IntLine{(0, 17.5, -0.035) -> (0, 17.5, 1.535)} CharImp=Zpi}} Impedance=50ohm
setups:
  Setup1: HfssDriven Frequency=2.45GHz MaxDeltaS=0.02 MaximumPasses=10 MinimumPasses=1 MinimumConvergedPasses=1 PercentRefinement=30 BasisOrder=1 PortAccuracy=2 DrivenSolverType="Direct Solver"
    sweep Sweep: 1.225GHz to 3.675GHz step 0.01GHz; Type=Fast SaveFields
source amplitudes:
  1:1: 1V 0deg
  2:1: 0V 0deg
field plots:
  Vector_E1: E Field over a plane on Setup1 : LastAdaptive at Freq=2.45GHz Phase=0deg
reports:
  S Parameter Plot 1: dB(S(1,1)), dB(S(2,1)) vs Freq on Setup1 : Sweep; markers m1 at 2.505GHz, m2 at 2.235GHz, m3 at 2.165GHz, m4 at 2.175GHz, m5 at 2.165GHz, m6 at 2.805GHz, m7 at 2.815GHz

design MCSRR_4_Rings (HFSS, HFSS Modal Network, model units mm)
geometry:
  Substrate [FR4_epoxy] = box(corner=(-12.5mm, -17.5mm, 0mm), size=(25mm, 35mm, 1.5mm))
  Cylinder1 = cylinder(axis=Z, base_centre=(0mm, 0mm, 3mm), radius=0.75mm, height=-12mm)
  Cylinder1_1 = Cylinder1.copy()
  Cylinder1_2 = Cylinder1.copy()
  Cylinder1_3 = Cylinder1.copy()
  Substrate.subtract(Cylinder1)
  Ground_Plane [copper] = rectangle(corner=(-12.5mm, 17.5mm, 1.5mm), x_size=25mm, y_size=-35mm)
  Outer_Circle = circle(normal=Z, centre=(0mm, 0mm, 1.5mm), radius=4.65mm)
  Circle1 = circle(normal=Z, centre=(0mm, 0mm, 1.5mm), radius=4.3mm)
  Outer_Circle.subtract(Circle1)
  Ground_Plane.subtract(Outer_Circle)
  Box1 = box(corner=(-4.65mm, 0mm, -1mm), size=(0.35mm, 0.7mm, 7mm))
  Ground_Plane.subtract(Box1)
  Almost_Outer_Circle = circle(normal=Z, centre=(0mm, 0mm, 1.5mm), radius=4mm)
  Circle2 = circle(normal=Z, centre=(0mm, 0mm, 1.5mm), radius=3.65mm)
  Almost_Outer_Circle.subtract(Circle2)
  Ground_Plane.subtract(Almost_Outer_Circle)
  Circle3 = circle(normal=Z, centre=(0mm, 0mm, 1.5mm), radius=3.35mm)
  Circle4 = circle(normal=Z, centre=(0mm, 0mm, 1.5mm), radius=3mm)
  Circle3.subtract(Circle4)
  Ground_Plane.subtract(Circle3)
  Circle5 = circle(normal=Z, centre=(0mm, 0mm, 1.5mm), radius=2.7mm)
  Circle6 = circle(normal=Z, centre=(0mm, 0mm, 1.5mm), radius=2.35mm)
  Circle5.subtract(Circle6)
  Ground_Plane.subtract(Circle5)
  Rectangle4 = rectangle(corner=(3.6mm, -0.35mm, 1.5mm), x_size=0.4mm, y_size=0.7mm)
  Ground_Plane.unite(Rectangle4)
  Rectangle3 = rectangle(corner=(2.3mm, -0.35mm, 1.5mm), x_size=0.4mm, y_size=0.7mm)
  Ground_Plane.unite(Rectangle3)
  Rectangle2 = rectangle(corner=(-3.35mm, -0.35mm, 1.5mm), x_size=0.4mm, y_size=0.7mm)
  Ground_Plane.unite(Rectangle2)
  Rectangle1 = rectangle(corner=(-4.65mm, -0.35mm, 1.5mm), x_size=0.4mm, y_size=0.7mm)
  Ground_Plane.unite(Rectangle1)
  Ground_Plane.subtract(Cylinder1_1)
  Ground_Plane.thicken(-35um)
  Microstrip_Circle [copper] = circle(normal=Z, centre=(0mm, 0mm, 0mm), radius=4.65mm)
  Microstrip_Circle.subtract(Cylinder1_3)
  Microstrip = rectangle(corner=(-1.325mm, -17.5mm, 0mm), x_size=2.65mm, y_size=35mm)
  Microstrip.subtract(Cylinder1_2)
  Microstrip_Circle.unite(Microstrip)
  Microstrip_Circle.thicken(-35um)
  Feedline1 = rectangle(corner=(-1.325mm, -17.5mm, 0mm), z_size=1.5mm, x_size=2.65mm)
  Feedline2 = rectangle(corner=(-1.325mm, 17.5mm, 0mm), z_size=1.5mm, x_size=2.65mm)
  Airbox [air] = box(corner=(-32.25mm, -31.75mm, -30.575mm), size=(64.5mm, 63.5mm, 61.15mm))
boundaries and excitations:
  Rad1: Radiation Objects=Airbox
  1: Lumped Port Objects=Feedline1 LumpedPortType=Modal Modes{Mode1{IntLine{(0, -17.5, -0.035) -> (0, -17.5, 1.5)} CharImp=Zpi}} Impedance=50ohm
  2: Lumped Port Objects=Feedline2 LumpedPortType=Modal Modes{Mode1{IntLine{(0, 17.5, 0) -> (0, 17.5, 1.5)} CharImp=Zpi}} Impedance=50ohm
setups:
  Setup1: HfssDriven Frequency=2.45GHz MaxDeltaS=0.02 MaximumPasses=10 MinimumPasses=1 MinimumConvergedPasses=1 PercentRefinement=30 BasisOrder=1 PortAccuracy=2 DrivenSolverType="Direct Solver"
    sweep Sweep: 1.225GHz to 3.675GHz step 0.01GHz; Type=Fast SaveFields
source amplitudes:
  1:1: 1V 0deg
  2:1: 0V 0deg
reports:
  S Parameter Plot 1: dB(S(1,1)), dB(S(2,1)) vs Freq on Setup1 : Sweep; markers m1 at 1.875GHz, m2 at 1.865GHz
